* Two-Stage Class AB Push-Pull Audio Amplifier
* LTspice AC frequency-response netlist
* Topology and model caveats are the same as the transient deck.

.param R_SOURCE_OHMS=600

VCC VCC 0 DC 9
VSIG SIG 0 DC 0 AC 1
R_SOURCE SIG NIN {R_SOURCE_OHMS}

CIN NIN NB1 10u
RF NB2 NB1 150k
RC VCC NB2 330

D1 NB2 NDMID D1N4007
D2 NDMID NC1 D1N4007
Q1 NC1 NB1 0 BC550C

Q2 VCC NB2 OUT BC337
Q3 0 NC1 OUT BC327

COUT OUT SPK 220u
RL SPK 0 16

.model BC550C NPN (IS=2.0e-14 BF=500 VAF=100 IKF=0.10 RB=50 RC=1 RE=0.5 CJE=12p CJC=5p TF=0.5n TR=50n)
.model BC337  NPN (IS=1.0e-14 BF=250 VAF=60 IKF=0.50 RB=20 RC=0.5 RE=0.2 CJE=40p CJC=20p TF=0.6n TR=100n)
.model BC327  PNP (IS=1.0e-14 BF=250 VAF=60 IKF=0.50 RB=20 RC=0.5 RE=0.2 CJE=40p CJC=20p TF=0.6n TR=100n)
.model D1N4007 D (IS=1.10e-8 N=1.78 RS=0.0414 CJO=28p VJ=0.508 M=0.319 TT=9.85u BV=1000 IBV=0.1)

.options plotwinsize=0
.temp 27
.ac dec 100 10 100k

* In the waveform viewer, plot VDB(V(SPK)/V(NIN)) for gain in dB
* and VP(V(SPK)/V(NIN)) for phase.
.meas AC GAIN_1KHZ FIND VDB(V(SPK)/V(NIN)) AT=1k
.end
